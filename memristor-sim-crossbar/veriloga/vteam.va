// VerilogA for Lab1, vteam, veriloga

`include "constants.vams"
`include "disciplines.vams"

module vteam(p, n);
	inout p, n;
	electrical p, n;

	parameter real ron = 2e6;
	parameter real roff = 50e6;
	parameter real voff = 0.7;
	parameter real von = -0.7;
	parameter real koff = 1e4;
	parameter real kon = -1e4;
	parameter real aoff = 3;
	parameter real aon = 3;
	parameter real xinit = 0.5;

	real v, x, xc, dxdt, r;

	analog begin
		v = V(p, n);

		if (v > voff)	dxdt = koff * pow(v/voff - 1, aoff);
		else if (v < von) 	dxdt = kon * pow(v/von - 1, aon);
		else 			dxdt = 0;

		if (x >= 1 && dxdt > 0) dxdt = 0;
		if (x <= 0 && dxdt < 0) dxdt = 0;

		x = idt(dxdt, xinit);
		xc = min(max(x, 0), 1);
		r = ron + (roff - ron) * xc;

		I(p, n) <+ v / r;
	end
endmodule
