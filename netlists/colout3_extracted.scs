// colout3, Quantus C-only coupled extraction (av_extracted), gpdk045.
// Pins: bln blp cas ref sum vdd vdp. Needs the gpdk045 Spectre models.
subckt colout3 bln blp cas ref sum vdd vdp
    I1\|I1\|C0_53__rcx (I1\|I1\|o1 I1\|g 0) g45cmim w=5.555e-06 \
        l=5.555e-06 m=1
    I1\|I1\|C0_52__rcx (I1\|I1\|o1 I1\|g 0) g45cmim w=5.555e-06 \
        l=5.555e-06 m=1
    I1\|I1\|C0_51__rcx (I1\|I1\|o1 I1\|g 0) g45cmim w=5.555e-06 \
        l=5.555e-06 m=1
    I1\|I1\|C0_50__rcx (I1\|I1\|o1 I1\|g 0) g45cmim w=5.555e-06 \
        l=5.555e-06 m=1
    I1\|I1\|C0_49__rcx (I1\|I1\|o1 I1\|g 0) g45cmim w=5.555e-06 \
        l=5.555e-06 m=1
    I1\|I1\|C0_48__rcx (I1\|I1\|o1 I1\|g 0) g45cmim w=5.555e-06 \
        l=5.555e-06 m=1
    I1\|I1\|C0_47__rcx (I1\|I1\|o1 I1\|g 0) g45cmim w=5.555e-06 \
        l=5.555e-06 m=1
    I1\|I1\|C0_46__rcx (I1\|I1\|o1 I1\|g 0) g45cmim w=5.555e-06 \
        l=5.555e-06 m=1
    I1\|I1\|C0_45__rcx (I1\|I1\|o1 I1\|g 0) g45cmim w=5.555e-06 \
        l=5.555e-06 m=1
    I1\|I1\|C0_44__rcx (I1\|I1\|o1 I1\|g 0) g45cmim w=5.555e-06 \
        l=5.555e-06 m=1
    I1\|I1\|C0_43__rcx (I1\|I1\|o1 I1\|g 0) g45cmim w=5.555e-06 \
        l=5.555e-06 m=1
    I1\|I1\|C0_42__rcx (I1\|I1\|o1 I1\|g 0) g45cmim w=5.555e-06 \
        l=5.555e-06 m=1
    I1\|I1\|C0_41__rcx (I1\|I1\|o1 I1\|g 0) g45cmim w=5.555e-06 \
        l=5.555e-06 m=1
    I1\|I1\|C0_40__rcx (I1\|I1\|o1 I1\|g 0) g45cmim w=5.555e-06 \
        l=5.555e-06 m=1
    I1\|I1\|C0_39__rcx (I1\|I1\|o1 I1\|g 0) g45cmim w=5.555e-06 \
        l=5.555e-06 m=1
    I1\|I1\|C0_38__rcx (I1\|I1\|o1 I1\|g 0) g45cmim w=5.555e-06 \
        l=5.555e-06 m=1
    I1\|I1\|C0_37__rcx (I1\|I1\|o1 I1\|g 0) g45cmim w=5.555e-06 \
        l=5.555e-06 m=1
    I1\|I1\|C0_36__rcx (I1\|I1\|o1 I1\|g 0) g45cmim w=5.555e-06 \
        l=5.555e-06 m=1
    I1\|I1\|C0_35__rcx (I1\|I1\|o1 I1\|g 0) g45cmim w=5.555e-06 \
        l=5.555e-06 m=1
    I1\|I1\|C0_34__rcx (I1\|I1\|o1 I1\|g 0) g45cmim w=5.555e-06 \
        l=5.555e-06 m=1
    I1\|I1\|C0_33__rcx (I1\|I1\|o1 I1\|g 0) g45cmim w=5.555e-06 \
        l=5.555e-06 m=1
    I1\|I1\|C0_32__rcx (I1\|I1\|o1 I1\|g 0) g45cmim w=5.555e-06 \
        l=5.555e-06 m=1
    I1\|I1\|C0_31__rcx (I1\|I1\|o1 I1\|g 0) g45cmim w=5.555e-06 \
        l=5.555e-06 m=1
    I1\|I1\|C0_30__rcx (I1\|I1\|o1 I1\|g 0) g45cmim w=5.555e-06 \
        l=5.555e-06 m=1
    I1\|I1\|C0_29__rcx (I1\|I1\|o1 I1\|g 0) g45cmim w=5.555e-06 \
        l=5.555e-06 m=1
    I1\|I1\|C0_28__rcx (I1\|I1\|o1 I1\|g 0) g45cmim w=5.555e-06 \
        l=5.555e-06 m=1
    I1\|I1\|C0_27__rcx (I1\|I1\|o1 I1\|g 0) g45cmim w=5.555e-06 \
        l=5.555e-06 m=1
    I1\|I1\|C0_26__rcx (I1\|I1\|o1 I1\|g 0) g45cmim w=5.555e-06 \
        l=5.555e-06 m=1
    I1\|I1\|C0_25__rcx (I1\|I1\|o1 I1\|g 0) g45cmim w=5.555e-06 \
        l=5.555e-06 m=1
    I1\|I1\|C0_24__rcx (I1\|I1\|o1 I1\|g 0) g45cmim w=5.555e-06 \
        l=5.555e-06 m=1
    I1\|I1\|C0_23__rcx (I1\|I1\|o1 I1\|g 0) g45cmim w=5.555e-06 \
        l=5.555e-06 m=1
    I1\|I1\|C0_22__rcx (I1\|I1\|o1 I1\|g 0) g45cmim w=5.555e-06 \
        l=5.555e-06 m=1
    I1\|I1\|C0_21__rcx (I1\|I1\|o1 I1\|g 0) g45cmim w=5.555e-06 \
        l=5.555e-06 m=1
    I1\|I1\|C0_20__rcx (I1\|I1\|o1 I1\|g 0) g45cmim w=5.555e-06 \
        l=5.555e-06 m=1
    I1\|I1\|C0_19__rcx (I1\|I1\|o1 I1\|g 0) g45cmim w=5.555e-06 \
        l=5.555e-06 m=1
    I1\|I1\|C0_18__rcx (I1\|I1\|o1 I1\|g 0) g45cmim w=5.555e-06 \
        l=5.555e-06 m=1
    I1\|I1\|C0_17__rcx (I1\|I1\|o1 I1\|g 0) g45cmim w=5.555e-06 \
        l=5.555e-06 m=1
    I1\|I1\|C0_16__rcx (I1\|I1\|o1 I1\|g 0) g45cmim w=5.555e-06 \
        l=5.555e-06 m=1
    I1\|I1\|C0_15__rcx (I1\|I1\|o1 I1\|g 0) g45cmim w=5.555e-06 \
        l=5.555e-06 m=1
    I1\|I1\|C0_14__rcx (I1\|I1\|o1 I1\|g 0) g45cmim w=5.555e-06 \
        l=5.555e-06 m=1
    I1\|I1\|C0_13__rcx (I1\|I1\|o1 I1\|g 0) g45cmim w=5.555e-06 \
        l=5.555e-06 m=1
    I1\|I1\|C0_12__rcx (I1\|I1\|o1 I1\|g 0) g45cmim w=5.555e-06 \
        l=5.555e-06 m=1
    I1\|I1\|C0_11__rcx (I1\|I1\|o1 I1\|g 0) g45cmim w=5.555e-06 \
        l=5.555e-06 m=1
    I1\|I1\|C0_10__rcx (I1\|I1\|o1 I1\|g 0) g45cmim w=5.555e-06 \
        l=5.555e-06 m=1
    I1\|I1\|C0_9__rcx (I1\|I1\|o1 I1\|g 0) g45cmim w=5.555e-06 l=5.555e-06 \
        m=1
    I1\|I1\|C0_8__rcx (I1\|I1\|o1 I1\|g 0) g45cmim w=5.555e-06 l=5.555e-06 \
        m=1
    I1\|I1\|C0_7__rcx (I1\|I1\|o1 I1\|g 0) g45cmim w=5.555e-06 l=5.555e-06 \
        m=1
    I1\|I1\|C0_6__rcx (I1\|I1\|o1 I1\|g 0) g45cmim w=5.555e-06 l=5.555e-06 \
        m=1
    I1\|I1\|C0_5__rcx (I1\|I1\|o1 I1\|g 0) g45cmim w=5.555e-06 l=5.555e-06 \
        m=1
    I1\|I1\|C0_4__rcx (I1\|I1\|o1 I1\|g 0) g45cmim w=5.555e-06 l=5.555e-06 \
        m=1
    I1\|I1\|C0_3__rcx (I1\|I1\|o1 I1\|g 0) g45cmim w=5.555e-06 l=5.555e-06 \
        m=1
    I1\|I1\|C0_2__rcx (I1\|I1\|o1 I1\|g 0) g45cmim w=5.555e-06 l=5.555e-06 \
        m=1
    I1\|I1\|C0_1__rcx (I1\|I1\|o1 I1\|g 0) g45cmim w=5.555e-06 l=5.555e-06 \
        m=1
    I1\|I1\|C0 (I1\|I1\|o1 I1\|g 0) g45cmim w=5.555e-06 l=5.555e-06 m=1
    I0\|I1\|C0_25__rcx (I0\|I1\|o1 I0\|g 0) g45cmim w=5.555e-06 \
        l=5.555e-06 m=1
    I0\|I1\|C0_37__rcx (I0\|I1\|o1 I0\|g 0) g45cmim w=5.555e-06 \
        l=5.555e-06 m=1
    I0\|I1\|C0_12__rcx (I0\|I1\|o1 I0\|g 0) g45cmim w=5.555e-06 \
        l=5.555e-06 m=1
    I0\|I1\|C0_10__rcx (I0\|I1\|o1 I0\|g 0) g45cmim w=5.555e-06 \
        l=5.555e-06 m=1
    I0\|I1\|C0_4__rcx (I0\|I1\|o1 I0\|g 0) g45cmim w=5.555e-06 l=5.555e-06 \
        m=1
    I0\|I1\|C0_13__rcx (I0\|I1\|o1 I0\|g 0) g45cmim w=5.555e-06 \
        l=5.555e-06 m=1
    I0\|I1\|C0_33__rcx (I0\|I1\|o1 I0\|g 0) g45cmim w=5.555e-06 \
        l=5.555e-06 m=1
    I0\|I1\|C0_53__rcx (I0\|I1\|o1 I0\|g 0) g45cmim w=5.555e-06 \
        l=5.555e-06 m=1
    I0\|I1\|C0_27__rcx (I0\|I1\|o1 I0\|g 0) g45cmim w=5.555e-06 \
        l=5.555e-06 m=1
    I0\|I1\|C0_39__rcx (I0\|I1\|o1 I0\|g 0) g45cmim w=5.555e-06 \
        l=5.555e-06 m=1
    I0\|I1\|C0_28__rcx (I0\|I1\|o1 I0\|g 0) g45cmim w=5.555e-06 \
        l=5.555e-06 m=1
    I0\|I1\|C0_26__rcx (I0\|I1\|o1 I0\|g 0) g45cmim w=5.555e-06 \
        l=5.555e-06 m=1
    I0\|I1\|C0_38__rcx (I0\|I1\|o1 I0\|g 0) g45cmim w=5.555e-06 \
        l=5.555e-06 m=1
    I0\|I1\|C0_23__rcx (I0\|I1\|o1 I0\|g 0) g45cmim w=5.555e-06 \
        l=5.555e-06 m=1
    I0\|I1\|C0_48__rcx (I0\|I1\|o1 I0\|g 0) g45cmim w=5.555e-06 \
        l=5.555e-06 m=1
    I0\|I1\|C0_22__rcx (I0\|I1\|o1 I0\|g 0) g45cmim w=5.555e-06 \
        l=5.555e-06 m=1
    I0\|I1\|C0_46__rcx (I0\|I1\|o1 I0\|g 0) g45cmim w=5.555e-06 \
        l=5.555e-06 m=1
    I0\|I1\|C0_20__rcx (I0\|I1\|o1 I0\|g 0) g45cmim w=5.555e-06 \
        l=5.555e-06 m=1
    I0\|I1\|C0_44__rcx (I0\|I1\|o1 I0\|g 0) g45cmim w=5.555e-06 \
        l=5.555e-06 m=1
    I0\|I1\|C0_8__rcx (I0\|I1\|o1 I0\|g 0) g45cmim w=5.555e-06 l=5.555e-06 \
        m=1
    I0\|I1\|C0_42__rcx (I0\|I1\|o1 I0\|g 0) g45cmim w=5.555e-06 \
        l=5.555e-06 m=1
    I0\|I1\|C0_17__rcx (I0\|I1\|o1 I0\|g 0) g45cmim w=5.555e-06 \
        l=5.555e-06 m=1
    I0\|I1\|C0_40__rcx (I0\|I1\|o1 I0\|g 0) g45cmim w=5.555e-06 \
        l=5.555e-06 m=1
    I0\|I1\|C0_7__rcx (I0\|I1\|o1 I0\|g 0) g45cmim w=5.555e-06 l=5.555e-06 \
        m=1
    I0\|I1\|C0_16__rcx (I0\|I1\|o1 I0\|g 0) g45cmim w=5.555e-06 \
        l=5.555e-06 m=1
    I0\|I1\|C0_15__rcx (I0\|I1\|o1 I0\|g 0) g45cmim w=5.555e-06 \
        l=5.555e-06 m=1
    I0\|I1\|C0_36__rcx (I0\|I1\|o1 I0\|g 0) g45cmim w=5.555e-06 \
        l=5.555e-06 m=1
    I0\|I1\|C0_50__rcx (I0\|I1\|o1 I0\|g 0) g45cmim w=5.555e-06 \
        l=5.555e-06 m=1
    I0\|I1\|C0_14__rcx (I0\|I1\|o1 I0\|g 0) g45cmim w=5.555e-06 \
        l=5.555e-06 m=1
    I0\|I1\|C0_5__rcx (I0\|I1\|o1 I0\|g 0) g45cmim w=5.555e-06 l=5.555e-06 \
        m=1
    I0\|I1\|C0_24__rcx (I0\|I1\|o1 I0\|g 0) g45cmim w=5.555e-06 \
        l=5.555e-06 m=1
    I0\|I1\|C0_3__rcx (I0\|I1\|o1 I0\|g 0) g45cmim w=5.555e-06 l=5.555e-06 \
        m=1
    I0\|I1\|C0_47__rcx (I0\|I1\|o1 I0\|g 0) g45cmim w=5.555e-06 \
        l=5.555e-06 m=1
    I0\|I1\|C0_41__rcx (I0\|I1\|o1 I0\|g 0) g45cmim w=5.555e-06 \
        l=5.555e-06 m=1
    I0\|I1\|C0_51__rcx (I0\|I1\|o1 I0\|g 0) g45cmim w=5.555e-06 \
        l=5.555e-06 m=1
    I0\|I1\|C0_2__rcx (I0\|I1\|o1 I0\|g 0) g45cmim w=5.555e-06 l=5.555e-06 \
        m=1
    I0\|I1\|C0_52__rcx (I0\|I1\|o1 I0\|g 0) g45cmim w=5.555e-06 \
        l=5.555e-06 m=1
    I0\|I1\|C0_21__rcx (I0\|I1\|o1 I0\|g 0) g45cmim w=5.555e-06 \
        l=5.555e-06 m=1
    I0\|I1\|C0_34__rcx (I0\|I1\|o1 I0\|g 0) g45cmim w=5.555e-06 \
        l=5.555e-06 m=1
    I0\|I1\|C0_1__rcx (I0\|I1\|o1 I0\|g 0) g45cmim w=5.555e-06 l=5.555e-06 \
        m=1
    I0\|I1\|C0_30__rcx (I0\|I1\|o1 I0\|g 0) g45cmim w=5.555e-06 \
        l=5.555e-06 m=1
    I0\|I1\|C0_49__rcx (I0\|I1\|o1 I0\|g 0) g45cmim w=5.555e-06 \
        l=5.555e-06 m=1
    I0\|I1\|C0_45__rcx (I0\|I1\|o1 I0\|g 0) g45cmim w=5.555e-06 \
        l=5.555e-06 m=1
    I0\|I1\|C0_9__rcx (I0\|I1\|o1 I0\|g 0) g45cmim w=5.555e-06 l=5.555e-06 \
        m=1
    I0\|I1\|C0_35__rcx (I0\|I1\|o1 I0\|g 0) g45cmim w=5.555e-06 \
        l=5.555e-06 m=1
    I0\|I1\|C0_18__rcx (I0\|I1\|o1 I0\|g 0) g45cmim w=5.555e-06 \
        l=5.555e-06 m=1
    I0\|I1\|C0_19__rcx (I0\|I1\|o1 I0\|g 0) g45cmim w=5.555e-06 \
        l=5.555e-06 m=1
    I0\|I1\|C0_6__rcx (I0\|I1\|o1 I0\|g 0) g45cmim w=5.555e-06 l=5.555e-06 \
        m=1
    I0\|I1\|C0_43__rcx (I0\|I1\|o1 I0\|g 0) g45cmim w=5.555e-06 \
        l=5.555e-06 m=1
    I0\|I1\|C0_32__rcx (I0\|I1\|o1 I0\|g 0) g45cmim w=5.555e-06 \
        l=5.555e-06 m=1
    I0\|I1\|C0_31__rcx (I0\|I1\|o1 I0\|g 0) g45cmim w=5.555e-06 \
        l=5.555e-06 m=1
    I0\|I1\|C0_29__rcx (I0\|I1\|o1 I0\|g 0) g45cmim w=5.555e-06 \
        l=5.555e-06 m=1
    I0\|I1\|C0_11__rcx (I0\|I1\|o1 I0\|g 0) g45cmim w=5.555e-06 \
        l=5.555e-06 m=1
    I0\|I1\|C0 (I0\|I1\|o1 I0\|g 0) g45cmim w=5.555e-06 l=5.555e-06 m=1
    I1\|I1\|MP1_1__rcx (I1\|I1\|n1 ref I1\|I1\|tail vdd) g45p1svt \
        w=(2e-06) l=4e-06 nf=1 as=2.8e-13 ad=2.8e-13 ps=4.28e-06 \
        pd=4.28e-06 nrd=1.16667 nrs=1.16667 sa=1.4e-07 sb=1.4e-07 sd=160n \
        sca=1.26243 scb=4.14693e-05 scc=1.56994e-08 m=(1)
    I1\|I1\|MP2_1__rcx (I1\|I1\|o1 bln I1\|I1\|tail vdd) g45p1svt \
        w=(2e-06) l=4e-06 nf=1 as=2.8e-13 ad=2.8e-13 ps=4.28e-06 \
        pd=4.28e-06 nrd=1.16667 nrs=1.16667 sa=1.4e-07 sb=1.4e-07 sd=160n \
        sca=1.26243 scb=4.14693e-05 scc=1.56994e-08 m=(1)
    I1\|I1\|MP2 (I1\|I1\|o1 bln I1\|I1\|tail vdd) g45p1svt w=(2e-06) \
        l=4e-06 nf=1 as=2.8e-13 ad=2.8e-13 ps=4.28e-06 pd=4.28e-06 \
        nrd=1.16667 nrs=1.16667 sa=1.4e-07 sb=1.4e-07 sd=160n sca=1.26243 \
        scb=4.14693e-05 scc=1.56994e-08 m=(1)
    I1\|I1\|MP1_2__rcx (I1\|I1\|n1 ref I1\|I1\|tail vdd) g45p1svt \
        w=(2e-06) l=4e-06 nf=1 as=2.8e-13 ad=2.8e-13 ps=4.28e-06 \
        pd=4.28e-06 nrd=1.16667 nrs=1.16667 sa=1.4e-07 sb=1.4e-07 sd=160n \
        sca=1.26243 scb=4.14693e-05 scc=1.56994e-08 m=(1)
    I1\|I1\|MP1_3__rcx (I1\|I1\|n1 ref I1\|I1\|tail vdd) g45p1svt \
        w=(2e-06) l=4e-06 nf=1 as=2.8e-13 ad=2.8e-13 ps=4.28e-06 \
        pd=4.28e-06 nrd=1.16667 nrs=1.16667 sa=1.4e-07 sb=1.4e-07 sd=160n \
        sca=1.26243 scb=4.14693e-05 scc=1.56994e-08 m=(1)
    I1\|I1\|MP2_3__rcx (I1\|I1\|o1 bln I1\|I1\|tail vdd) g45p1svt \
        w=(2e-06) l=4e-06 nf=1 as=2.8e-13 ad=2.8e-13 ps=4.28e-06 \
        pd=4.28e-06 nrd=1.16667 nrs=1.16667 sa=1.4e-07 sb=1.4e-07 sd=160n \
        sca=1.26243 scb=4.14693e-05 scc=1.56994e-08 m=(1)
    I1\|I1\|MP2_2__rcx (I1\|I1\|o1 bln I1\|I1\|tail vdd) g45p1svt \
        w=(2e-06) l=4e-06 nf=1 as=2.8e-13 ad=2.8e-13 ps=4.28e-06 \
        pd=4.28e-06 nrd=1.16667 nrs=1.16667 sa=1.4e-07 sb=1.4e-07 sd=160n \
        sca=1.26243 scb=4.14693e-05 scc=1.56994e-08 m=(1)
    I1\|I1\|MP1 (I1\|I1\|n1 ref I1\|I1\|tail vdd) g45p1svt w=(2e-06) \
        l=4e-06 nf=1 as=2.8e-13 ad=2.8e-13 ps=4.28e-06 pd=4.28e-06 \
        nrd=1.16667 nrs=1.16667 sa=1.4e-07 sb=1.4e-07 sd=160n sca=1.26243 \
        scb=4.14693e-05 scc=1.56994e-08 m=(1)
    I0\|I1\|MP1_3__rcx (I0\|I1\|n1 ref I0\|I1\|tail vdd) g45p1svt \
        w=(2e-06) l=4e-06 nf=1 as=2.8e-13 ad=2.8e-13 ps=4.28e-06 \
        pd=4.28e-06 nrd=1.16667 nrs=1.16667 sa=1.4e-07 sb=1.4e-07 sd=160n \
        sca=1.26243 scb=4.14693e-05 scc=1.56994e-08 m=(1)
    I0\|I1\|MP2_1__rcx (I0\|I1\|o1 blp I0\|I1\|tail vdd) g45p1svt \
        w=(2e-06) l=4e-06 nf=1 as=2.8e-13 ad=2.8e-13 ps=4.28e-06 \
        pd=4.28e-06 nrd=1.16667 nrs=1.16667 sa=1.4e-07 sb=1.4e-07 sd=160n \
        sca=1.26243 scb=4.14693e-05 scc=1.56994e-08 m=(1)
    I0\|I1\|MP2 (I0\|I1\|o1 blp I0\|I1\|tail vdd) g45p1svt w=(2e-06) \
        l=4e-06 nf=1 as=2.8e-13 ad=2.8e-13 ps=4.28e-06 pd=4.28e-06 \
        nrd=1.16667 nrs=1.16667 sa=1.4e-07 sb=1.4e-07 sd=160n sca=1.26243 \
        scb=4.14693e-05 scc=1.56994e-08 m=(1)
    I0\|I1\|MP1_1__rcx (I0\|I1\|n1 ref I0\|I1\|tail vdd) g45p1svt \
        w=(2e-06) l=4e-06 nf=1 as=2.8e-13 ad=2.8e-13 ps=4.28e-06 \
        pd=4.28e-06 nrd=1.16667 nrs=1.16667 sa=1.4e-07 sb=1.4e-07 sd=160n \
        sca=1.26243 scb=4.14693e-05 scc=1.56994e-08 m=(1)
    I0\|I1\|MP1_2__rcx (I0\|I1\|n1 ref I0\|I1\|tail vdd) g45p1svt \
        w=(2e-06) l=4e-06 nf=1 as=2.8e-13 ad=2.8e-13 ps=4.28e-06 \
        pd=4.28e-06 nrd=1.16667 nrs=1.16667 sa=1.4e-07 sb=1.4e-07 sd=160n \
        sca=1.26243 scb=4.14693e-05 scc=1.56994e-08 m=(1)
    I0\|I1\|MP2_3__rcx (I0\|I1\|o1 blp I0\|I1\|tail vdd) g45p1svt \
        w=(2e-06) l=4e-06 nf=1 as=2.8e-13 ad=2.8e-13 ps=4.28e-06 \
        pd=4.28e-06 nrd=1.16667 nrs=1.16667 sa=1.4e-07 sb=1.4e-07 sd=160n \
        sca=1.26243 scb=4.14693e-05 scc=1.56994e-08 m=(1)
    I0\|I1\|MP2_2__rcx (I0\|I1\|o1 blp I0\|I1\|tail vdd) g45p1svt \
        w=(2e-06) l=4e-06 nf=1 as=2.8e-13 ad=2.8e-13 ps=4.28e-06 \
        pd=4.28e-06 nrd=1.16667 nrs=1.16667 sa=1.4e-07 sb=1.4e-07 sd=160n \
        sca=1.26243 scb=4.14693e-05 scc=1.56994e-08 m=(1)
    I0\|I1\|MP1 (I0\|I1\|n1 ref I0\|I1\|tail vdd) g45p1svt w=(2e-06) \
        l=4e-06 nf=1 as=2.8e-13 ad=2.8e-13 ps=4.28e-06 pd=4.28e-06 \
        nrd=1.16667 nrs=1.16667 sa=1.4e-07 sb=1.4e-07 sd=160n sca=1.26243 \
        scb=4.14693e-05 scc=1.56994e-08 m=(1)
    C109 (vdd I0\|x) capacitor c=3.12254e-17
    C110 (cas bln) capacitor c=2.35955e-16
    C111 (ref bln) capacitor c=3.21839e-15
    C112 (py pg1) capacitor c=4.56148e-16
    C113 (cas blp) capacitor c=2.35955e-16
    C114 (bln vdd) capacitor c=2.49288e-15
    C115 (I1\|vgr vdd) capacitor c=3.24866e-17
    C116 (vdp bln) capacitor c=2.5471e-16
    C117 (ref blp) capacitor c=3.21724e-15
    C118 (blp vdd) capacitor c=2.49226e-15
    C119 (vdp I0\|x) capacitor c=2.25836e-17
    C120 (vdp blp) capacitor c=2.20714e-16
    C121 (bln I1\|vgr) capacitor c=1.48347e-16
    C122 (sum cas) capacitor c=1.9394e-16
    C123 (cas vdd) capacitor c=6.92177e-16
    C124 (vdp I1\|vgr) capacitor c=1.42077e-16
    C125 (blp I0\|vgr) capacitor c=1.48347e-16
    C126 (I0\|g blp) capacitor c=9.277e-17
    C127 (pg2 cas) capacitor c=1.9394e-16
    C128 (I0\|net2 blp) capacitor c=9.81831e-17
    C129 (I0\|x pg2) capacitor c=3.44993e-17
    C130 (ref vdd) capacitor c=3.43838e-15
    C131 (I0\|g cas) capacitor c=6.40006e-17
    C132 (vdp ref) capacitor c=1.91676e-16
    C133 (sum vdd) capacitor c=4.08178e-16
    C134 (cas I0\|net2) capacitor c=2.31871e-16
    C135 (cas I0\|x) capacitor c=2.45494e-16
    C136 (sum pg2) capacitor c=1.92917e-16
    C137 (vdp vdd) capacitor c=8.87144e-15
    C138 (ref I0\|vgr) capacitor c=3.87422e-16
    C139 (pg2 vdd) capacitor c=9.71208e-16
    C140 (I0\|g ref) capacitor c=1.03165e-16
    C141 (pg1 vdd) capacitor c=2.53919e-15
    C142 (py vdd) capacitor c=5.04226e-16
    C143 (I0\|g I0\|net2) capacitor c=6.22458e-16
    C144 (ref I1\|vgr) capacitor c=3.87422e-16
    C145 (I0\|vgr vdd) capacitor c=3.03837e-17
    C146 (pg2 pg1) capacitor c=2.98566e-16
    C147 (I0\|x I0\|g) capacitor c=5.16473e-16
    C148 (I0\|g vdd) capacitor c=1.11092e-15
    C149 (vdp I0\|vgr) capacitor c=1.42013e-16
    C150 (pg2 py) capacitor c=4.49797e-16
    C151 (I0\|g vdp) capacitor c=1.70884e-15
    C152 (ref I1\|I1\|o1) capacitor c=1.5231e-16
    C153 (I1\|I1\|o1 I1\|I1\|n1) capacitor c=2.1354e-15
    C154 (ref I1\|I1\|tail) capacitor c=8.77099e-16
    C155 (I1\|x I1\|g) capacitor c=5.16592e-16
    C156 (sum I1\|x) capacitor c=3.47508e-17
    C157 (ref I0\|I1\|n1) capacitor c=2.07953e-15
    C158 (I0\|I1\|tail I0\|g) capacitor c=1.13324e-16
    C159 (I1\|g vdd) capacitor c=1.10687e-15
    C160 (ref I0\|I1\|o1) capacitor c=1.47838e-16
    C161 (bln I1\|g) capacitor c=9.277e-17
    C162 (bln I1\|net2) capacitor c=9.8299e-17
    C163 (bln I1\|I1\|n1) capacitor c=1.27525e-16
    C164 (ref I0\|I1\|tail) capacitor c=8.77099e-16
    C165 (I1\|I1\|tail I1\|I1\|n1) capacitor c=1.12473e-16
    C166 (bln I1\|I1\|o1) capacitor c=5.41653e-16
    C167 (bln I1\|I1\|tail) capacitor c=9.62557e-16
    C168 (I1\|g I1\|I1\|n1) capacitor c=1.51428e-16
    C169 (I0\|I1\|o1 I0\|I1\|n1) capacitor c=2.13266e-15
    C170 (I1\|x vdd) capacitor c=3.11499e-17
    C171 (vdp I1\|g) capacitor c=1.70604e-15
    C172 (I1\|I1\|n1 vdd) capacitor c=1.99681e-16
    C173 (I1\|I1\|o1 vdd) capacitor c=2.17297e-16
    C174 (I1\|g I1\|I1\|o1) capacitor c=1.6267e-13
    C175 (I1\|I1\|tail I1\|I1\|o1) capacitor c=1.43425e-16
    C176 (blp I0\|I1\|n1) capacitor c=1.27346e-16
    C177 (vdp I1\|x) capacitor c=2.25836e-17
    C178 (blp I0\|I1\|o1) capacitor c=5.41743e-16
    C179 (I1\|I1\|tail vdd) capacitor c=2.38816e-15
    C180 (blp I0\|I1\|tail) capacitor c=9.62557e-16
    C181 (I0\|I1\|tail I0\|I1\|n1) capacitor c=1.12473e-16
    C182 (I1\|g cas) capacitor c=6.40006e-17
    C183 (cas I1\|net2) capacitor c=2.31915e-16
    C184 (I0\|I1\|n1 vdd) capacitor c=2.01605e-16
    C185 (cas I1\|x) capacitor c=2.45531e-16
    C186 (I1\|g I1\|I1\|tail) capacitor c=1.14364e-16
    C187 (I0\|I1\|o1 vdd) capacitor c=2.17297e-16
    C188 (I0\|I1\|tail vdd) capacitor c=2.38816e-15
    C189 (vdp I1\|I1\|tail) capacitor c=2.72803e-16
    C190 (I0\|I1\|tail I0\|I1\|o1) capacitor c=1.43425e-16
    C191 (ref I1\|g) capacitor c=1.02192e-16
    C192 (I0\|g I0\|I1\|n1) capacitor c=1.5159e-16
    C193 (vdp I0\|I1\|tail) capacitor c=2.72803e-16
    C194 (I1\|g I1\|net2) capacitor c=6.22458e-16
    C195 (ref I1\|I1\|n1) capacitor c=2.0773e-15
    C196 (I0\|I1\|o1 I0\|g) capacitor c=1.62648e-13
    C197 (bln 0) capacitor c=1.1718e-15
    C198 (blp 0) capacitor c=1.16403e-15
    C199 (cas 0) capacitor c=2.53544e-15
    C200 (ref 0) capacitor c=3.7236e-15
    C201 (sum 0) capacitor c=1.25564e-15
    C202 (vdd 0) capacitor c=4.29422e-15
    C203 (vdp 0) capacitor c=2.02763e-15
    C204 (pg2 0) capacitor c=1.46026e-15
    C205 (py 0) capacitor c=6.15786e-18
    C206 (I0\|vgr 0) capacitor c=7.8403e-16
    C207 (I0\|g 0) capacitor c=2.33884e-14
    C208 (I0\|net2 0) capacitor c=3.59579e-16
    C209 (I0\|x 0) capacitor c=4.13822e-16
    C210 (I1\|vgr 0) capacitor c=7.86364e-16
    C211 (I1\|g 0) capacitor c=2.34005e-14
    C212 (I1\|net2 0) capacitor c=3.59557e-16
    C213 (I1\|x 0) capacitor c=4.13735e-16
    C214 (I1\|I1\|n1 0) capacitor c=7.58067e-15
    C215 (I1\|I1\|o1 0) capacitor c=1.43116e-14
    C216 (I0\|I1\|n1 0) capacitor c=7.58254e-15
    C217 (I0\|I1\|o1 0) capacitor c=1.4293e-14
    I1\|NM4 (bln I1\|vgr ref 0) g45n1svt w=(2e-06) l=4e-06 nf=1 as=2.8e-13 \
        ad=2.8e-13 ps=4.28e-06 pd=4.28e-06 nrd=1.16667 nrs=1.16667 \
        sa=1.4e-07 sb=1.4e-07 sd=160n sca=1.06667 scb=7.49099e-06 \
        scc=1.62316e-10 m=(1)
    I1\|NM5 (I1\|vgr I1\|vgr ref 0) g45n1svt w=(2e-06) l=4e-06 nf=1 \
        as=2.8e-13 ad=2.8e-13 ps=4.28e-06 pd=4.28e-06 nrd=1.16667 \
        nrs=1.16667 sa=1.4e-07 sb=1.4e-07 sd=160n sca=1.45294 \
        scb=0.00016572 scc=4.48947e-07 m=(1)
    I1\|I1\|MN1_3__rcx (I1\|I1\|n1 I1\|I1\|n1 0 0) g45n1svt w=(2e-06) \
        l=4e-06 nf=1 as=2.8e-13 ad=2.8e-13 ps=4.28e-06 pd=4.28e-06 \
        nrd=1.16667 nrs=1.16667 sa=1.4e-07 sb=1.4e-07 sd=160n sca=1.06667 \
        scb=7.49099e-06 scc=1.62316e-10 m=(1)
    I1\|I1\|MN2_3__rcx (I1\|I1\|o1 I1\|I1\|n1 0 0) g45n1svt w=(2e-06) \
        l=4e-06 nf=1 as=2.8e-13 ad=2.8e-13 ps=4.28e-06 pd=4.28e-06 \
        nrd=1.16667 nrs=1.16667 sa=1.4e-07 sb=1.4e-07 sd=160n sca=1.06667 \
        scb=7.49099e-06 scc=1.62316e-10 m=(1)
    I1\|I1\|MN2_2__rcx (I1\|I1\|o1 I1\|I1\|n1 0 0) g45n1svt w=(2e-06) \
        l=4e-06 nf=1 as=2.8e-13 ad=2.8e-13 ps=4.28e-06 pd=4.28e-06 \
        nrd=1.16667 nrs=1.16667 sa=1.4e-07 sb=1.4e-07 sd=160n sca=1.06667 \
        scb=7.49099e-06 scc=1.62316e-10 m=(1)
    I1\|I1\|MN1_1__rcx (I1\|I1\|n1 I1\|I1\|n1 0 0) g45n1svt w=(2e-06) \
        l=4e-06 nf=1 as=2.8e-13 ad=2.8e-13 ps=4.28e-06 pd=4.28e-06 \
        nrd=1.16667 nrs=1.16667 sa=1.4e-07 sb=1.4e-07 sd=160n sca=1.06667 \
        scb=7.49099e-06 scc=1.62316e-10 m=(1)
    I1\|I1\|MN1_2__rcx (I1\|I1\|n1 I1\|I1\|n1 0 0) g45n1svt w=(2e-06) \
        l=4e-06 nf=1 as=2.8e-13 ad=2.8e-13 ps=4.28e-06 pd=4.28e-06 \
        nrd=1.16667 nrs=1.16667 sa=1.4e-07 sb=1.4e-07 sd=160n sca=1.06667 \
        scb=7.49099e-06 scc=1.62316e-10 m=(1)
    I1\|I1\|MN2_1__rcx (I1\|I1\|o1 I1\|I1\|n1 0 0) g45n1svt w=(2e-06) \
        l=4e-06 nf=1 as=2.8e-13 ad=2.8e-13 ps=4.28e-06 pd=4.28e-06 \
        nrd=1.16667 nrs=1.16667 sa=1.4e-07 sb=1.4e-07 sd=160n sca=1.06667 \
        scb=7.49099e-06 scc=1.62316e-10 m=(1)
    I1\|I1\|MN2 (I1\|I1\|o1 I1\|I1\|n1 0 0) g45n1svt w=(2e-06) l=4e-06 \
        nf=1 as=2.8e-13 ad=2.8e-13 ps=4.28e-06 pd=4.28e-06 nrd=1.16667 \
        nrs=1.16667 sa=1.4e-07 sb=1.4e-07 sd=160n sca=1.06667 \
        scb=7.49099e-06 scc=1.62316e-10 m=(1)
    I1\|I1\|MN1 (I1\|I1\|n1 I1\|I1\|n1 0 0) g45n1svt w=(2e-06) l=4e-06 \
        nf=1 as=2.8e-13 ad=2.8e-13 ps=4.28e-06 pd=4.28e-06 nrd=1.16667 \
        nrs=1.16667 sa=1.4e-07 sb=1.4e-07 sd=160n sca=1.06667 \
        scb=7.49099e-06 scc=1.62316e-10 m=(1)
    I0\|NM4 (blp I0\|vgr ref 0) g45n1svt w=(2e-06) l=4e-06 nf=1 as=2.8e-13 \
        ad=2.8e-13 ps=4.28e-06 pd=4.28e-06 nrd=1.16667 nrs=1.16667 \
        sa=1.4e-07 sb=1.4e-07 sd=160n sca=1.06667 scb=7.49099e-06 \
        scc=1.62316e-10 m=(1)
    I0\|NM5 (I0\|vgr I0\|vgr ref 0) g45n1svt w=(2e-06) l=4e-06 nf=1 \
        as=2.8e-13 ad=2.8e-13 ps=4.28e-06 pd=4.28e-06 nrd=1.16667 \
        nrs=1.16667 sa=1.4e-07 sb=1.4e-07 sd=160n sca=1.45294 \
        scb=0.00016572 scc=4.48947e-07 m=(1)
    I0\|I1\|MN1_1__rcx (I0\|I1\|n1 I0\|I1\|n1 0 0) g45n1svt w=(2e-06) \
        l=4e-06 nf=1 as=2.8e-13 ad=2.8e-13 ps=4.28e-06 pd=4.28e-06 \
        nrd=1.16667 nrs=1.16667 sa=1.4e-07 sb=1.4e-07 sd=160n sca=1.06667 \
        scb=7.49099e-06 scc=1.62316e-10 m=(1)
    I0\|I1\|MN2_3__rcx (I0\|I1\|o1 I0\|I1\|n1 0 0) g45n1svt w=(2e-06) \
        l=4e-06 nf=1 as=2.8e-13 ad=2.8e-13 ps=4.28e-06 pd=4.28e-06 \
        nrd=1.16667 nrs=1.16667 sa=1.4e-07 sb=1.4e-07 sd=160n sca=1.06667 \
        scb=7.49099e-06 scc=1.62316e-10 m=(1)
    I0\|I1\|MN2_2__rcx (I0\|I1\|o1 I0\|I1\|n1 0 0) g45n1svt w=(2e-06) \
        l=4e-06 nf=1 as=2.8e-13 ad=2.8e-13 ps=4.28e-06 pd=4.28e-06 \
        nrd=1.16667 nrs=1.16667 sa=1.4e-07 sb=1.4e-07 sd=160n sca=1.06667 \
        scb=7.49099e-06 scc=1.62316e-10 m=(1)
    I0\|I1\|MN1_3__rcx (I0\|I1\|n1 I0\|I1\|n1 0 0) g45n1svt w=(2e-06) \
        l=4e-06 nf=1 as=2.8e-13 ad=2.8e-13 ps=4.28e-06 pd=4.28e-06 \
        nrd=1.16667 nrs=1.16667 sa=1.4e-07 sb=1.4e-07 sd=160n sca=1.06667 \
        scb=7.49099e-06 scc=1.62316e-10 m=(1)
    I0\|I1\|MN1_2__rcx (I0\|I1\|n1 I0\|I1\|n1 0 0) g45n1svt w=(2e-06) \
        l=4e-06 nf=1 as=2.8e-13 ad=2.8e-13 ps=4.28e-06 pd=4.28e-06 \
        nrd=1.16667 nrs=1.16667 sa=1.4e-07 sb=1.4e-07 sd=160n sca=1.06667 \
        scb=7.49099e-06 scc=1.62316e-10 m=(1)
    I0\|I1\|MN2 (I0\|I1\|o1 I0\|I1\|n1 0 0) g45n1svt w=(2e-06) l=4e-06 \
        nf=1 as=2.8e-13 ad=2.8e-13 ps=4.28e-06 pd=4.28e-06 nrd=1.16667 \
        nrs=1.16667 sa=1.4e-07 sb=1.4e-07 sd=160n sca=1.06667 \
        scb=7.49099e-06 scc=1.62316e-10 m=(1)
    I0\|I1\|MN2_1__rcx (I0\|I1\|o1 I0\|I1\|n1 0 0) g45n1svt w=(2e-06) \
        l=4e-06 nf=1 as=2.8e-13 ad=2.8e-13 ps=4.28e-06 pd=4.28e-06 \
        nrd=1.16667 nrs=1.16667 sa=1.4e-07 sb=1.4e-07 sd=160n sca=1.06667 \
        scb=7.49099e-06 scc=1.62316e-10 m=(1)
    I0\|I1\|MN1 (I0\|I1\|n1 I0\|I1\|n1 0 0) g45n1svt w=(2e-06) l=4e-06 \
        nf=1 as=2.8e-13 ad=2.8e-13 ps=4.28e-06 pd=4.28e-06 nrd=1.16667 \
        nrs=1.16667 sa=1.4e-07 sb=1.4e-07 sd=160n sca=1.06667 \
        scb=7.49099e-06 scc=1.62316e-10 m=(1)
    I1\|I1\|MN3_1__rcx (I1\|g I1\|I1\|o1 0 0) g45n1svt w=(2e-06) l=2e-06 \
        nf=1 as=2.8e-13 ad=2.8e-13 ps=4.28e-06 pd=4.28e-06 nrd=1.16667 \
        nrs=1.16667 sa=1.4e-07 sb=1.4e-07 sd=160n sca=1.33333 \
        scb=9.98798e-06 scc=2.16421e-10 m=(1)
    I1\|I1\|MN3_8__rcx (I1\|g I1\|I1\|o1 0 0) g45n1svt w=(2e-06) l=2e-06 \
        nf=1 as=2.8e-13 ad=2.8e-13 ps=4.28e-06 pd=4.28e-06 nrd=1.16667 \
        nrs=1.16667 sa=1.4e-07 sb=1.4e-07 sd=160n sca=1.33333 \
        scb=9.98798e-06 scc=2.16421e-10 m=(1)
    I1\|I1\|MN3_9__rcx (I1\|g I1\|I1\|o1 0 0) g45n1svt w=(2e-06) l=2e-06 \
        nf=1 as=2.8e-13 ad=2.8e-13 ps=4.28e-06 pd=4.28e-06 nrd=1.16667 \
        nrs=1.16667 sa=1.4e-07 sb=1.4e-07 sd=160n sca=1.33333 \
        scb=9.98798e-06 scc=2.16421e-10 m=(1)
    I1\|I1\|MN3_6__rcx (I1\|g I1\|I1\|o1 0 0) g45n1svt w=(2e-06) l=2e-06 \
        nf=1 as=2.8e-13 ad=2.8e-13 ps=4.28e-06 pd=4.28e-06 nrd=1.16667 \
        nrs=1.16667 sa=1.4e-07 sb=1.4e-07 sd=160n sca=1.33333 \
        scb=9.98798e-06 scc=2.16421e-10 m=(1)
    I1\|I1\|MN3_7__rcx (I1\|g I1\|I1\|o1 0 0) g45n1svt w=(2e-06) l=2e-06 \
        nf=1 as=2.8e-13 ad=2.8e-13 ps=4.28e-06 pd=4.28e-06 nrd=1.16667 \
        nrs=1.16667 sa=1.4e-07 sb=1.4e-07 sd=160n sca=1.33333 \
        scb=9.98798e-06 scc=2.16421e-10 m=(1)
    I1\|I1\|MN3_12__rcx (I1\|g I1\|I1\|o1 0 0) g45n1svt w=(2e-06) l=2e-06 \
        nf=1 as=2.8e-13 ad=2.8e-13 ps=4.28e-06 pd=4.28e-06 nrd=1.16667 \
        nrs=1.16667 sa=1.4e-07 sb=1.4e-07 sd=160n sca=1.33333 \
        scb=9.98798e-06 scc=2.16421e-10 m=(1)
    I1\|I1\|MN3_13__rcx (I1\|g I1\|I1\|o1 0 0) g45n1svt w=(2e-06) l=2e-06 \
        nf=1 as=2.8e-13 ad=2.8e-13 ps=4.28e-06 pd=4.28e-06 nrd=1.16667 \
        nrs=1.16667 sa=1.4e-07 sb=1.4e-07 sd=160n sca=1.33333 \
        scb=9.98798e-06 scc=2.16421e-10 m=(1)
    I1\|I1\|MN3_10__rcx (I1\|g I1\|I1\|o1 0 0) g45n1svt w=(2e-06) l=2e-06 \
        nf=1 as=2.8e-13 ad=2.8e-13 ps=4.28e-06 pd=4.28e-06 nrd=1.16667 \
        nrs=1.16667 sa=1.4e-07 sb=1.4e-07 sd=160n sca=1.33333 \
        scb=9.98798e-06 scc=2.16421e-10 m=(1)
    I1\|I1\|MN3 (I1\|g I1\|I1\|o1 0 0) g45n1svt w=(2e-06) l=2e-06 nf=1 \
        as=2.8e-13 ad=2.8e-13 ps=4.28e-06 pd=4.28e-06 nrd=1.16667 \
        nrs=1.16667 sa=1.4e-07 sb=1.4e-07 sd=160n sca=1.33333 \
        scb=9.98798e-06 scc=2.16421e-10 m=(1)
    I1\|I1\|MN3_2__rcx (I1\|g I1\|I1\|o1 0 0) g45n1svt w=(2e-06) l=2e-06 \
        nf=1 as=2.8e-13 ad=2.8e-13 ps=4.28e-06 pd=4.28e-06 nrd=1.16667 \
        nrs=1.16667 sa=1.4e-07 sb=1.4e-07 sd=160n sca=1.33333 \
        scb=9.98798e-06 scc=2.16421e-10 m=(1)
    I1\|I1\|MN3_5__rcx (I1\|g I1\|I1\|o1 0 0) g45n1svt w=(2e-06) l=2e-06 \
        nf=1 as=2.8e-13 ad=2.8e-13 ps=4.28e-06 pd=4.28e-06 nrd=1.16667 \
        nrs=1.16667 sa=1.4e-07 sb=1.4e-07 sd=160n sca=1.33333 \
        scb=9.98798e-06 scc=2.16421e-10 m=(1)
    I1\|I1\|MN3_11__rcx (I1\|g I1\|I1\|o1 0 0) g45n1svt w=(2e-06) l=2e-06 \
        nf=1 as=2.8e-13 ad=2.8e-13 ps=4.28e-06 pd=4.28e-06 nrd=1.16667 \
        nrs=1.16667 sa=1.4e-07 sb=1.4e-07 sd=160n sca=1.33333 \
        scb=9.98798e-06 scc=2.16421e-10 m=(1)
    I1\|I1\|MN3_3__rcx (I1\|g I1\|I1\|o1 0 0) g45n1svt w=(2e-06) l=2e-06 \
        nf=1 as=2.8e-13 ad=2.8e-13 ps=4.28e-06 pd=4.28e-06 nrd=1.16667 \
        nrs=1.16667 sa=1.4e-07 sb=1.4e-07 sd=160n sca=1.33333 \
        scb=9.98798e-06 scc=2.16421e-10 m=(1)
    I1\|I1\|MN3_4__rcx (I1\|g I1\|I1\|o1 0 0) g45n1svt w=(2e-06) l=2e-06 \
        nf=1 as=2.8e-13 ad=2.8e-13 ps=4.28e-06 pd=4.28e-06 nrd=1.16667 \
        nrs=1.16667 sa=1.4e-07 sb=1.4e-07 sd=160n sca=1.33333 \
        scb=9.98798e-06 scc=2.16421e-10 m=(1)
    I1\|I1\|MN3_19__rcx (I1\|g I1\|I1\|o1 0 0) g45n1svt w=(2e-06) l=2e-06 \
        nf=1 as=2.8e-13 ad=2.8e-13 ps=4.28e-06 pd=4.28e-06 nrd=1.16667 \
        nrs=1.16667 sa=1.4e-07 sb=1.4e-07 sd=160n sca=1.33333 \
        scb=9.98798e-06 scc=2.16421e-10 m=(1)
    I1\|I1\|MN3_17__rcx (I1\|g I1\|I1\|o1 0 0) g45n1svt w=(2e-06) l=2e-06 \
        nf=1 as=2.8e-13 ad=2.8e-13 ps=4.28e-06 pd=4.28e-06 nrd=1.16667 \
        nrs=1.16667 sa=1.4e-07 sb=1.4e-07 sd=160n sca=1.33333 \
        scb=9.98798e-06 scc=2.16421e-10 m=(1)
    I1\|I1\|MN3_18__rcx (I1\|g I1\|I1\|o1 0 0) g45n1svt w=(2e-06) l=2e-06 \
        nf=1 as=2.8e-13 ad=2.8e-13 ps=4.28e-06 pd=4.28e-06 nrd=1.16667 \
        nrs=1.16667 sa=1.4e-07 sb=1.4e-07 sd=160n sca=1.33333 \
        scb=9.98798e-06 scc=2.16421e-10 m=(1)
    I1\|I1\|MN3_16__rcx (I1\|g I1\|I1\|o1 0 0) g45n1svt w=(2e-06) l=2e-06 \
        nf=1 as=2.8e-13 ad=2.8e-13 ps=4.28e-06 pd=4.28e-06 nrd=1.16667 \
        nrs=1.16667 sa=1.4e-07 sb=1.4e-07 sd=160n sca=1.33333 \
        scb=9.98798e-06 scc=2.16421e-10 m=(1)
    I1\|I1\|MN3_14__rcx (I1\|g I1\|I1\|o1 0 0) g45n1svt w=(2e-06) l=2e-06 \
        nf=1 as=2.8e-13 ad=2.8e-13 ps=4.28e-06 pd=4.28e-06 nrd=1.16667 \
        nrs=1.16667 sa=1.4e-07 sb=1.4e-07 sd=160n sca=1.33333 \
        scb=9.98798e-06 scc=2.16421e-10 m=(1)
    I1\|I1\|MN3_15__rcx (I1\|g I1\|I1\|o1 0 0) g45n1svt w=(2e-06) l=2e-06 \
        nf=1 as=2.8e-13 ad=2.8e-13 ps=4.28e-06 pd=4.28e-06 nrd=1.16667 \
        nrs=1.16667 sa=1.4e-07 sb=1.4e-07 sd=160n sca=1.33333 \
        scb=9.98798e-06 scc=2.16421e-10 m=(1)
    I0\|I1\|MN3_13__rcx (I0\|g I0\|I1\|o1 0 0) g45n1svt w=(2e-06) l=2e-06 \
        nf=1 as=2.8e-13 ad=2.8e-13 ps=4.28e-06 pd=4.28e-06 nrd=1.16667 \
        nrs=1.16667 sa=1.4e-07 sb=1.4e-07 sd=160n sca=1.33333 \
        scb=9.98798e-06 scc=2.16421e-10 m=(1)
    I0\|I1\|MN3_1__rcx (I0\|g I0\|I1\|o1 0 0) g45n1svt w=(2e-06) l=2e-06 \
        nf=1 as=2.8e-13 ad=2.8e-13 ps=4.28e-06 pd=4.28e-06 nrd=1.16667 \
        nrs=1.16667 sa=1.4e-07 sb=1.4e-07 sd=160n sca=1.33333 \
        scb=9.98798e-06 scc=2.16421e-10 m=(1)
    I0\|I1\|MN3_3__rcx (I0\|g I0\|I1\|o1 0 0) g45n1svt w=(2e-06) l=2e-06 \
        nf=1 as=2.8e-13 ad=2.8e-13 ps=4.28e-06 pd=4.28e-06 nrd=1.16667 \
        nrs=1.16667 sa=1.4e-07 sb=1.4e-07 sd=160n sca=1.33333 \
        scb=9.98798e-06 scc=2.16421e-10 m=(1)
    I0\|I1\|MN3_8__rcx (I0\|g I0\|I1\|o1 0 0) g45n1svt w=(2e-06) l=2e-06 \
        nf=1 as=2.8e-13 ad=2.8e-13 ps=4.28e-06 pd=4.28e-06 nrd=1.16667 \
        nrs=1.16667 sa=1.4e-07 sb=1.4e-07 sd=160n sca=1.33333 \
        scb=9.98798e-06 scc=2.16421e-10 m=(1)
    I0\|I1\|MN3_12__rcx (I0\|g I0\|I1\|o1 0 0) g45n1svt w=(2e-06) l=2e-06 \
        nf=1 as=2.8e-13 ad=2.8e-13 ps=4.28e-06 pd=4.28e-06 nrd=1.16667 \
        nrs=1.16667 sa=1.4e-07 sb=1.4e-07 sd=160n sca=1.33333 \
        scb=9.98798e-06 scc=2.16421e-10 m=(1)
    I0\|I1\|MN3 (I0\|g I0\|I1\|o1 0 0) g45n1svt w=(2e-06) l=2e-06 nf=1 \
        as=2.8e-13 ad=2.8e-13 ps=4.28e-06 pd=4.28e-06 nrd=1.16667 \
        nrs=1.16667 sa=1.4e-07 sb=1.4e-07 sd=160n sca=1.33333 \
        scb=9.98798e-06 scc=2.16421e-10 m=(1)
    I0\|I1\|MN3_18__rcx (I0\|g I0\|I1\|o1 0 0) g45n1svt w=(2e-06) l=2e-06 \
        nf=1 as=2.8e-13 ad=2.8e-13 ps=4.28e-06 pd=4.28e-06 nrd=1.16667 \
        nrs=1.16667 sa=1.4e-07 sb=1.4e-07 sd=160n sca=1.33333 \
        scb=9.98798e-06 scc=2.16421e-10 m=(1)
    I0\|I1\|MN3_17__rcx (I0\|g I0\|I1\|o1 0 0) g45n1svt w=(2e-06) l=2e-06 \
        nf=1 as=2.8e-13 ad=2.8e-13 ps=4.28e-06 pd=4.28e-06 nrd=1.16667 \
        nrs=1.16667 sa=1.4e-07 sb=1.4e-07 sd=160n sca=1.33333 \
        scb=9.98798e-06 scc=2.16421e-10 m=(1)
    I0\|I1\|MN3_19__rcx (I0\|g I0\|I1\|o1 0 0) g45n1svt w=(2e-06) l=2e-06 \
        nf=1 as=2.8e-13 ad=2.8e-13 ps=4.28e-06 pd=4.28e-06 nrd=1.16667 \
        nrs=1.16667 sa=1.4e-07 sb=1.4e-07 sd=160n sca=1.33333 \
        scb=9.98798e-06 scc=2.16421e-10 m=(1)
    I0\|I1\|MN3_7__rcx (I0\|g I0\|I1\|o1 0 0) g45n1svt w=(2e-06) l=2e-06 \
        nf=1 as=2.8e-13 ad=2.8e-13 ps=4.28e-06 pd=4.28e-06 nrd=1.16667 \
        nrs=1.16667 sa=1.4e-07 sb=1.4e-07 sd=160n sca=1.33333 \
        scb=9.98798e-06 scc=2.16421e-10 m=(1)
    I0\|I1\|MN3_9__rcx (I0\|g I0\|I1\|o1 0 0) g45n1svt w=(2e-06) l=2e-06 \
        nf=1 as=2.8e-13 ad=2.8e-13 ps=4.28e-06 pd=4.28e-06 nrd=1.16667 \
        nrs=1.16667 sa=1.4e-07 sb=1.4e-07 sd=160n sca=1.33333 \
        scb=9.98798e-06 scc=2.16421e-10 m=(1)
    I0\|I1\|MN3_10__rcx (I0\|g I0\|I1\|o1 0 0) g45n1svt w=(2e-06) l=2e-06 \
        nf=1 as=2.8e-13 ad=2.8e-13 ps=4.28e-06 pd=4.28e-06 nrd=1.16667 \
        nrs=1.16667 sa=1.4e-07 sb=1.4e-07 sd=160n sca=1.33333 \
        scb=9.98798e-06 scc=2.16421e-10 m=(1)
    I0\|I1\|MN3_16__rcx (I0\|g I0\|I1\|o1 0 0) g45n1svt w=(2e-06) l=2e-06 \
        nf=1 as=2.8e-13 ad=2.8e-13 ps=4.28e-06 pd=4.28e-06 nrd=1.16667 \
        nrs=1.16667 sa=1.4e-07 sb=1.4e-07 sd=160n sca=1.33333 \
        scb=9.98798e-06 scc=2.16421e-10 m=(1)
    I0\|I1\|MN3_4__rcx (I0\|g I0\|I1\|o1 0 0) g45n1svt w=(2e-06) l=2e-06 \
        nf=1 as=2.8e-13 ad=2.8e-13 ps=4.28e-06 pd=4.28e-06 nrd=1.16667 \
        nrs=1.16667 sa=1.4e-07 sb=1.4e-07 sd=160n sca=1.33333 \
        scb=9.98798e-06 scc=2.16421e-10 m=(1)
    I0\|I1\|MN3_14__rcx (I0\|g I0\|I1\|o1 0 0) g45n1svt w=(2e-06) l=2e-06 \
        nf=1 as=2.8e-13 ad=2.8e-13 ps=4.28e-06 pd=4.28e-06 nrd=1.16667 \
        nrs=1.16667 sa=1.4e-07 sb=1.4e-07 sd=160n sca=1.33333 \
        scb=9.98798e-06 scc=2.16421e-10 m=(1)
    I0\|I1\|MN3_5__rcx (I0\|g I0\|I1\|o1 0 0) g45n1svt w=(2e-06) l=2e-06 \
        nf=1 as=2.8e-13 ad=2.8e-13 ps=4.28e-06 pd=4.28e-06 nrd=1.16667 \
        nrs=1.16667 sa=1.4e-07 sb=1.4e-07 sd=160n sca=1.33333 \
        scb=9.98798e-06 scc=2.16421e-10 m=(1)
    I0\|I1\|MN3_15__rcx (I0\|g I0\|I1\|o1 0 0) g45n1svt w=(2e-06) l=2e-06 \
        nf=1 as=2.8e-13 ad=2.8e-13 ps=4.28e-06 pd=4.28e-06 nrd=1.16667 \
        nrs=1.16667 sa=1.4e-07 sb=1.4e-07 sd=160n sca=1.33333 \
        scb=9.98798e-06 scc=2.16421e-10 m=(1)
    I0\|I1\|MN3_6__rcx (I0\|g I0\|I1\|o1 0 0) g45n1svt w=(2e-06) l=2e-06 \
        nf=1 as=2.8e-13 ad=2.8e-13 ps=4.28e-06 pd=4.28e-06 nrd=1.16667 \
        nrs=1.16667 sa=1.4e-07 sb=1.4e-07 sd=160n sca=1.33333 \
        scb=9.98798e-06 scc=2.16421e-10 m=(1)
    I0\|I1\|MN3_11__rcx (I0\|g I0\|I1\|o1 0 0) g45n1svt w=(2e-06) l=2e-06 \
        nf=1 as=2.8e-13 ad=2.8e-13 ps=4.28e-06 pd=4.28e-06 nrd=1.16667 \
        nrs=1.16667 sa=1.4e-07 sb=1.4e-07 sd=160n sca=1.33333 \
        scb=9.98798e-06 scc=2.16421e-10 m=(1)
    I0\|I1\|MN3_2__rcx (I0\|g I0\|I1\|o1 0 0) g45n1svt w=(2e-06) l=2e-06 \
        nf=1 as=2.8e-13 ad=2.8e-13 ps=4.28e-06 pd=4.28e-06 nrd=1.16667 \
        nrs=1.16667 sa=1.4e-07 sb=1.4e-07 sd=160n sca=1.33333 \
        scb=9.98798e-06 scc=2.16421e-10 m=(1)
    I1\|NM2 (sum cas I1\|x 0) g45n1svt w=(4e-06) l=2e-06 nf=1 as=5.6e-13 \
        ad=5.6e-13 ps=8.28e-06 pd=8.28e-06 nrd=1.16667 nrs=1.16667 \
        sa=1.4e-07 sb=1.4e-07 sd=160n sca=1.06667 scb=7.49099e-06 \
        scc=1.62316e-10 m=(1)
    I1\|NM3 (bln cas I1\|net2 0) g45n1svt w=(4e-06) l=2e-06 nf=1 \
        as=5.6e-13 ad=5.6e-13 ps=8.28e-06 pd=8.28e-06 nrd=1.16667 \
        nrs=1.16667 sa=1.4e-07 sb=1.4e-07 sd=160n sca=1.06667 \
        scb=7.49099e-06 scc=1.62316e-10 m=(1)
    I0\|NM2 (pg2 cas I0\|x 0) g45n1svt w=(4e-06) l=2e-06 nf=1 as=5.6e-13 \
        ad=5.6e-13 ps=8.28e-06 pd=8.28e-06 nrd=1.16667 nrs=1.16667 \
        sa=1.4e-07 sb=1.4e-07 sd=160n sca=1.06667 scb=7.49099e-06 \
        scc=1.62316e-10 m=(1)
    I0\|NM3 (blp cas I0\|net2 0) g45n1svt w=(4e-06) l=2e-06 nf=1 \
        as=5.6e-13 ad=5.6e-13 ps=8.28e-06 pd=8.28e-06 nrd=1.16667 \
        nrs=1.16667 sa=1.4e-07 sb=1.4e-07 sd=160n sca=1.06667 \
        scb=7.49099e-06 scc=1.62316e-10 m=(1)
    I1\|NM0 (I1\|net2 I1\|g 0 0) g45n1svt w=(8e-06) l=4e-06 nf=1 \
        as=1.12e-12 ad=1.12e-12 ps=1.628e-05 pd=1.628e-05 nrd=1.16667 \
        nrs=1.16667 sa=1.4e-07 sb=1.4e-07 sd=160n sca=0.644345 \
        scb=6.89782e-06 scc=1.17293e-09 m=(1)
    I1\|NM1 (I1\|x I1\|g 0 0) g45n1svt w=(8e-06) l=4e-06 nf=1 as=1.12e-12 \
        ad=1.12e-12 ps=1.628e-05 pd=1.628e-05 nrd=1.16667 nrs=1.16667 \
        sa=1.4e-07 sb=1.4e-07 sd=160n sca=0.646031 scb=5.31656e-06 \
        scc=2.03736e-10 m=(1)
    I0\|NM0 (I0\|net2 I0\|g 0 0) g45n1svt w=(8e-06) l=4e-06 nf=1 \
        as=1.12e-12 ad=1.12e-12 ps=1.628e-05 pd=1.628e-05 nrd=1.16667 \
        nrs=1.16667 sa=1.4e-07 sb=1.4e-07 sd=160n sca=0.644345 \
        scb=6.89782e-06 scc=1.17293e-09 m=(1)
    I0\|NM1 (I0\|x I0\|g 0 0) g45n1svt w=(8e-06) l=4e-06 nf=1 as=1.12e-12 \
        ad=1.12e-12 ps=1.628e-05 pd=1.628e-05 nrd=1.16667 nrs=1.16667 \
        sa=1.4e-07 sb=1.4e-07 sd=160n sca=0.646031 scb=5.31656e-06 \
        scc=2.03736e-10 m=(1)
    I1\|I1\|PB2_2__rcx (I1\|g vdp vdd vdd) g45p1svt w=(4e-06) l=2e-06 nf=1 \
        as=5.6e-13 ad=5.6e-13 ps=8.28e-06 pd=8.28e-06 nrd=1.16667 \
        nrs=1.16667 sa=1.4e-07 sb=1.4e-07 sd=160n sca=1.06667 \
        scb=7.49099e-06 scc=1.62316e-10 m=(1)
    I1\|I1\|PB2_1__rcx (I1\|g vdp vdd vdd) g45p1svt w=(4e-06) l=2e-06 nf=1 \
        as=5.6e-13 ad=5.6e-13 ps=8.28e-06 pd=8.28e-06 nrd=1.16667 \
        nrs=1.16667 sa=1.4e-07 sb=1.4e-07 sd=160n sca=1.06667 \
        scb=7.49099e-06 scc=1.62316e-10 m=(1)
    I1\|I1\|PB1 (I1\|I1\|tail vdp vdd vdd) g45p1svt w=(4e-06) l=2e-06 nf=1 \
        as=5.6e-13 ad=5.6e-13 ps=8.28e-06 pd=8.28e-06 nrd=1.16667 \
        nrs=1.16667 sa=1.4e-07 sb=1.4e-07 sd=160n sca=1.06667 \
        scb=7.49099e-06 scc=1.62316e-10 m=(1)
    I1\|I1\|PB2 (I1\|g vdp vdd vdd) g45p1svt w=(4e-06) l=2e-06 nf=1 \
        as=5.6e-13 ad=5.6e-13 ps=8.28e-06 pd=8.28e-06 nrd=1.16667 \
        nrs=1.16667 sa=1.4e-07 sb=1.4e-07 sd=160n sca=1.06667 \
        scb=7.49099e-06 scc=1.62316e-10 m=(1)
    I1\|I1\|PB2_3__rcx (I1\|g vdp vdd vdd) g45p1svt w=(4e-06) l=2e-06 nf=1 \
        as=5.6e-13 ad=5.6e-13 ps=8.28e-06 pd=8.28e-06 nrd=1.16667 \
        nrs=1.16667 sa=1.4e-07 sb=1.4e-07 sd=160n sca=1.06667 \
        scb=7.49099e-06 scc=1.62316e-10 m=(1)
    I0\|I1\|PB2_3__rcx (I0\|g vdp vdd vdd) g45p1svt w=(4e-06) l=2e-06 nf=1 \
        as=5.6e-13 ad=5.6e-13 ps=8.28e-06 pd=8.28e-06 nrd=1.16667 \
        nrs=1.16667 sa=1.4e-07 sb=1.4e-07 sd=160n sca=1.06667 \
        scb=7.49099e-06 scc=1.62316e-10 m=(1)
    I0\|I1\|PB2_2__rcx (I0\|g vdp vdd vdd) g45p1svt w=(4e-06) l=2e-06 nf=1 \
        as=5.6e-13 ad=5.6e-13 ps=8.28e-06 pd=8.28e-06 nrd=1.16667 \
        nrs=1.16667 sa=1.4e-07 sb=1.4e-07 sd=160n sca=1.06667 \
        scb=7.49099e-06 scc=1.62316e-10 m=(1)
    I0\|I1\|PB1 (I0\|I1\|tail vdp vdd vdd) g45p1svt w=(4e-06) l=2e-06 nf=1 \
        as=5.6e-13 ad=5.6e-13 ps=8.28e-06 pd=8.28e-06 nrd=1.16667 \
        nrs=1.16667 sa=1.4e-07 sb=1.4e-07 sd=160n sca=1.06667 \
        scb=7.49099e-06 scc=1.62316e-10 m=(1)
    I0\|I1\|PB2_1__rcx (I0\|g vdp vdd vdd) g45p1svt w=(4e-06) l=2e-06 nf=1 \
        as=5.6e-13 ad=5.6e-13 ps=8.28e-06 pd=8.28e-06 nrd=1.16667 \
        nrs=1.16667 sa=1.4e-07 sb=1.4e-07 sd=160n sca=1.06667 \
        scb=7.49099e-06 scc=1.62316e-10 m=(1)
    I0\|I1\|PB2 (I0\|g vdp vdd vdd) g45p1svt w=(4e-06) l=2e-06 nf=1 \
        as=5.6e-13 ad=5.6e-13 ps=8.28e-06 pd=8.28e-06 nrd=1.16667 \
        nrs=1.16667 sa=1.4e-07 sb=1.4e-07 sd=160n sca=1.06667 \
        scb=7.49099e-06 scc=1.62316e-10 m=(1)
    PM3 (sum pg2 py vdd) g45p1svt w=(4e-06) l=2e-06 nf=1 as=5.6e-13 \
        ad=5.6e-13 ps=8.28e-06 pd=8.28e-06 nrd=1.16667 nrs=1.16667 \
        sa=1.4e-07 sb=1.4e-07 sd=160n sca=1.06667 scb=7.49099e-06 \
        scc=1.62316e-10 m=(1)
    PM2 (pg2 pg2 pg1 vdd) g45p1svt w=(4e-06) l=2e-06 nf=1 as=5.6e-13 \
        ad=5.6e-13 ps=8.28e-06 pd=8.28e-06 nrd=1.16667 nrs=1.16667 \
        sa=1.4e-07 sb=1.4e-07 sd=160n sca=1.06667 scb=7.49099e-06 \
        scc=1.62316e-10 m=(1)
    I1\|PBR (I1\|vgr vdp vdd vdd) g45p1svt w=(6.4e-07) l=2.5e-06 nf=1 \
        as=8.96e-14 ad=8.96e-14 ps=1.56e-06 pd=1.56e-06 nrd=1.16667 \
        nrs=1.16667 sa=1.4e-07 sb=1.4e-07 sd=160n sca=3.84279 \
        scb=0.00138733 scc=9.91309e-06 m=(1)
    I0\|PBR (I0\|vgr vdp vdd vdd) g45p1svt w=(6.4e-07) l=2.5e-06 nf=1 \
        as=8.96e-14 ad=8.96e-14 ps=1.56e-06 pd=1.56e-06 nrd=1.16667 \
        nrs=1.16667 sa=1.4e-07 sb=1.4e-07 sd=160n sca=3.84279 \
        scb=0.00138733 scc=9.91309e-06 m=(1)
    PM1 (py pg1 vdd vdd) g45p1svt w=(8e-06) l=4e-06 nf=1 as=1.12e-12 \
        ad=1.12e-12 ps=1.628e-05 pd=1.628e-05 nrd=1.16667 nrs=1.16667 \
        sa=1.4e-07 sb=1.4e-07 sd=160n sca=0.807458 scb=4.22088e-05 \
        scc=3.65264e-08 m=(1)
    PM0 (pg1 pg1 vdd vdd) g45p1svt w=(8e-06) l=4e-06 nf=1 as=1.12e-12 \
        ad=1.12e-12 ps=1.628e-05 pd=1.628e-05 nrd=1.16667 nrs=1.16667 \
        sa=1.4e-07 sb=1.4e-07 sd=160n sca=0.807458 scb=4.22088e-05 \
        scc=3.65264e-08 m=(1)
ends colout3
